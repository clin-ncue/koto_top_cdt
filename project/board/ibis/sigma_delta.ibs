[IBIS Ver] 3.2
[File Name] sigma_delta.ibs
[File Rev] 4.9
[Date] October 21, 2016
[Source] Altera, Quartus II 64-Bit 9.1
[Notes]
| The models are designated as "Final" and have been
| correlated against physical device operation.
Unused IOs which have been assigned as tri-stated inputs or
as outputs driving any signal in Quartus II are represented by the NC.
[Disclaimer] Data is for modeling purposes only and is not guaranteed.
[Copyright] Copyright (C) 1991-2010 Altera Corporation
[Component] EP2S90F1020C3_sigma_delta
[Manufacturer]  Altera Corporation
[Package]
| RLC values are for 1020 FBGA package
|variable  typ  min  max
R_pkg  163.00m   81.00m   594.00m
L_pkg  1.00nH   0.50nH   3.82nH
C_pkg  0.73pF   0.50pF   1.93pF
[Pin]  signal_name   model_name   R_pin   L_pin   C_pin
A2   GND   GND
A3   VCCIO4   POWER
A5   1_RXD[11]   2s_ttl33_cin
A6   1_RXD[6]   2s_ttl33_cin
A7   1_ENABLE   2s_ttl33_cio_d24
A8   am[1]   2s_ttl33_cin
A10   1_TXD[14]   2s_ttl33_cio_r25
A12   1_RXD[8]   2s_ttl33_cin
A13   GND   GND
A14   1_TX_ER   2s_ttl33_cio_d24
A15   VCCIO4   POWER
A16   sysclk   2s_ttl33_cin
A18   VCCIO3   POWER
A20   GND   GND
A21   vme_data[10]   2s_ttl33_cio_d24
A22   vme_data[9]   2s_ttl33_cio_d24
A23   address[2]   2s_ttl33_cin
A24   0_TXD[11]   2s_ttl33_cio_r25
A25   0_TXD[7]   2s_ttl33_cio_r25
A26   0_TXD[10]   2s_ttl33_cio_r25
A27   0_RXD[11]   2s_ttl33_cin
A28   0_RXD[12]   2s_ttl33_cin
A29   _as   2s_ttl33_cin
A30   VCCIO3   POWER
A31   GND   GND
AA5   VCCIO6   POWER
AA12   VCCINT   POWER
AA13   VCCPD7   POWER
AA14   GND   GND
AA15   VCCPD7   POWER
AA16   VCCIO7   POWER
AA17   VCCIO8   POWER
AA18   VCCPD8   POWER
AA19   GND   GND
AA20   VCCPD8   POWER
AA21   GND   GND
AA28   VCCIO1   POWER
AA29   inputbus[8](n)   2s_lvds25_rin_t100
AA30   inputbus[8]   2s_lvds25_rin_t100
AA31   Debug_LVDS_IN_0(n)   2s_lvds25_rin_t100
AA32   Debug_LVDS_IN_0   2s_lvds25_rin_t100
AB5   2nd_outputbus[0]   2s_lvds25_ro
AB6   2nd_outputbus[0](n)   2s_lvds25_ro
AB11   2_RXD[2]   2s_ttl33_cin
AB12   2_TXD[6]   2s_ttl33_cio_r25
AB14   2_RX_DV   2s_ttl33_cio_d24
AB15   debug[17]   2s_ttl33_cio_d24
AB16   2_TX_EN   2s_ttl33_cio_d24
AB17   vme_data[19]   2s_ttl33_cio_d24
AB18   address[26]   2s_ttl33_cin
AB19   address[21]   2s_ttl33_cin
AB20   address[31]   2s_ttl33_cin
AB21   3_RXD[3]   2s_ttl33_cin
AB22   GND   GND
AB27   inputbus[15](n)   2s_lvds25_rin_t100
AB28   inputbus[15]   2s_lvds25_rin_t100
AB29   inputbus[10](n)   2s_lvds25_rin_t100
AB30   inputbus[10]   2s_lvds25_rin_t100
AB31   inputbus[14](n)   2s_lvds25_rin_t100
AB32   inputbus[14]   2s_lvds25_rin_t100
AC5   GND   GND
AC10   VCCINT   POWER
AC11   2_RXD[15]   2s_ttl33_cin
AC12   2_RX_ER   2s_ttl33_cio_d24
AC13   2_TXD[9]   2s_ttl33_cio_r25
AC14   2_RXD[3]   2s_ttl33_cin
AC15   debug[19]   2s_ttl33_cio_d24
AC16   2_LCKREFN   2s_ttl33_cio_d24
AC17   vme_data[30]   2s_ttl33_cio_d24
AC18   vme_data[17]   2s_ttl33_cio_d24
AC19   address[25]   2s_ttl33_cin
AC20   address[28]   2s_ttl33_cin
AC21   3_RXD[6]   2s_ttl33_cin
AC22   debug[9]   2s_ttl33_cio_d24
AC23   VCCSEL   2s_ttl33_cin
AC28   GND   GND
AC31   inputbus[11](n)   2s_lvds25_rin_t100
AC32   inputbus[11]   2s_lvds25_rin_t100
AD5   VREFB6   POWER
AD15   VCCD_PLL6   POWER
AD16   NC   NC
AD17   NC   NC
AD18   vme_data[31]   2s_ttl33_cio_d24
AD19   vme_data[20]   2s_ttl33_cio_d24
AD21   debug[5]   2s_ttl33_cio_d24
AD22   3_TXD[15]   2s_ttl33_cio_r25
AD23   3_RXD[8]   2s_ttl33_cin
AD28   VREFB1   POWER
AD31   inputbus[9](n)   2s_lvds25_rin_t100
AD32   inputbus[9]   2s_lvds25_rin_t100
AE7   VCCA_PLL9   POWER
AE8   VCCD_PLL9   POWER
AE9   ~CONFIGURE_AS_INPUT_  2s_ttl33_cin
AE10   2_RXD[12]   2s_ttl33_cin
AE12   2_TXD[4]   2s_ttl33_cio_r25
AE13   2_TXD[12]   2s_ttl33_cio_r25
AE15   VCCA_PLL6   POWER
AE16   NC   NC
AE17   NC   NC
AE18   VCCD_PLL12   POWER
AE19   vme_data[22]   2s_ttl33_cio_d24
AE20   3_RXD[7]   2s_ttl33_cin
AE21   3_TXD[6]   2s_ttl33_cio_r25
AE22   3_RXD[15]   2s_ttl33_cin
AE23   3_ENABLE   2s_ttl33_cio_d24
AE24   TMS   2s_ttl33_cin
AE29   inputbus[4](n)   2s_lvds25_rin_t100
AE30   inputbus[4]   2s_lvds25_rin_t100
AE31   inputbus[13](n)   2s_lvds25_rin_t100
AE32   inputbus[13]   2s_lvds25_rin_t100
AF5   ~CONFIGURE_AS_INPUT_  2s_ttl25_rrin
AF6   ~CONFIGURE_AS_INPUT_  2s_ttl25_rrin
AF7   NC   NC
AF9   GND   GND
AF10   2_TXD[10]   2s_ttl33_cio_r25
AF11   2_TXD[1]   2s_ttl33_cio_r25
AF12   2_TXD[11]   2s_ttl33_cio_r25
AF14   ~CONFIGURE_AS_INPUT_  2s_ttl33_cin
AF15   VCC_PLL6_OUT   POWER
AF16   VCC_PLL12_OUT   POWER
AF17   GND   GND
AF18   VCCA_PLL12   POWER
AF19   vme_data[29]   2s_ttl33_cio_d24
AF20   3_RXD[13]   2s_ttl33_cin
AF21   debug[11]   2s_ttl33_cio_d24
AF22   3_RX_CLK   2s_ttl33_cin
AF23   3_RXD[11]   2s_ttl33_cin
AF24   TCK   2s_ttl33_cin
AF25   VCCD_PLL8   POWER
AF26   VCCA_PLL8   POWER
AF27   ~CONFIGURE_AS_INPUT_  2s_ttl25_rrin
AF28   ~CONFIGURE_AS_INPUT_  2s_ttl25_rrin
AF29   inputbus[5](n)   2s_lvds25_rin_t100
AF30   inputbus[5]   2s_lvds25_rin_t100
AF31   inputbus[1](n)   2s_lvds25_rin_t100
AF32   inputbus[1]   2s_lvds25_rin_t100
AG5   VREFB6   POWER
AG6   GND   GND
AG7   NC   NC
AG9   2_RXD[7]   2s_ttl33_cin
AG10   2_TXD[15]   2s_ttl33_cio_r25
AG11   2_TXD[3]   2s_ttl33_cio_r25
AG12   2_TXD[14]   2s_ttl33_cio_r25
AG16   clkswitch   2s_ttl33_cin
AG17   vme_data[21]   2s_ttl33_cio_d24
AG18   vme_data[27]   2s_ttl33_cio_d24
AG19   vme_data[28]   2s_ttl33_cio_d24
AG20   3_TXD[9]   2s_ttl33_cio_r25
AG21   ~CONFIGURE_AS_INPUT_  2s_ttl33_cin
AG22   3_LCKREFN   2s_ttl33_cio_d24
AG23   transceivers_OE   2s_ttl33_cio_d24
AG24   3_RXD[5]   2s_ttl33_cin
AG25   ~CONFIGURE_AS_INPUT_  2s_ttl33_cin
AG26   NC   NC
AG27   NC   NC
AG28   VREFB1   POWER
AG29   inputbus[7](n)   2s_lvds25_rin_t100
AG30   inputbus[7]   2s_lvds25_rin_t100
AG31   inputbus[3](n)   2s_lvds25_rin_t100
AG32   inputbus[3]   2s_lvds25_rin_t100
AH6   2_RXD[0]   2s_ttl33_cin
AH7   debug[16]   2s_ttl33_cio_d24
AH8   2_RXD[10]   2s_ttl33_cin
AH10   GND   GND
AH12   VCCIO7   POWER
AH15   3_XCLK   2s_ttl33_cio_d24
AH17   vme_data[16]   2s_ttl33_cio_d24
AH19   vme_data[26]   2s_ttl33_cio_d24
AH20   address[24]   2s_ttl33_cin
AH21   VCCIO8   POWER
AH22   address[27]   2s_ttl33_cin
AH23   GND   GND
AH24   3_RXD[2]   2s_ttl33_cin
AH25   3_RXD[1]   2s_ttl33_cin
AH26   3_RX_DV   2s_ttl33_cio_d24
AH27   GND   GND
AH28   3_TXD[4]   2s_ttl33_cio_r25
AH29   inputbus[2](n)   2s_lvds25_rin_t100
AH30   inputbus[2]   2s_lvds25_rin_t100
AH31   inputbus[6](n)   2s_lvds25_rin_t100
AH32   inputbus[6]   2s_lvds25_rin_t100
AJ5   2_RX_CLK   2s_ttl33_cin
AJ8   2_TXD[2]   2s_ttl33_cio_r25
AJ9   VREFB7   POWER
AJ10   2_TXD[7]   2s_ttl33_cio_r25
AJ13   2_RXD[1]   2s_ttl33_cin
AJ15   0_XCLK   2s_ttl33_cio_d24
AJ16   ClockSwitchControl[3  2s_ttl33_cio_d24
AJ19   vme_data[18]   2s_ttl33_cio_d24
AJ20   address[18]   2s_ttl33_cin
AJ21   address[20]   2s_ttl33_cin
AJ22   3_TX_EN   2s_ttl33_cio_d24
AJ23   address[30]   2s_ttl33_cin
AJ24   VREFB8   POWER
AJ25   3_RXD[10]   2s_ttl33_cin
AJ26   debug[3]   2s_ttl33_cio_d24
AJ27   3_TXD[0]   2s_ttl33_cio_r25
AJ28   3_TXD[14]   2s_ttl33_cio_r25
AJ31   inputbus[0](n)   2s_lvds25_rin_t100
AJ32   inputbus[0]   2s_lvds25_rin_t100
AK1   VCCIO6   POWER
AK2   VREFB7   POWER
AK3   nIO_PULLUP   2s_ttl33_cin
AK6   2_RXD[14]   2s_ttl33_cin
AK8   2_TXD[8]   2s_ttl33_cio_r25
AK9   2_TXD[5]   2s_ttl33_cio_r25
AK11   debug[7]   2s_ttl33_cio_d24
AK12   debug[13]   2s_ttl33_cio_d24
AK13   2_ENABLE   2s_ttl33_cio_d24
AK14   VREFB7   POWER
AK16   1_XCLK   2s_ttl33_cio_d24
AK19   VREFB8   POWER
AK20   vme_data[25]   2s_ttl33_cio_d24
AK21   address[22]   2s_ttl33_cin
AK22   address[29]   2s_ttl33_cin
AK23   _vme_write   2s_ttl33_cin
AK24   address[16]   2s_ttl33_cin
AK25   3_RXD[4]   2s_ttl33_cin
AK26   3_TXD[3]   2s_ttl33_cio_r25
AK27   3_TXD[12]   2s_ttl33_cio_r25
AK28   3_TXD[2]   2s_ttl33_cio_r25
AK29   3_RXD[12]   2s_ttl33_cin
AK30   TRST   2s_ttl33_cin
AK31   VREFB8   POWER
AK32   VCCIO1   POWER
AL1   GND   GND
AL2   PORSEL   2s_ttl33_cin
AL3   nCEO   2s_ttl33_nceo
AL4   2_RXD[11]   2s_ttl33_cin
AL6   2_RXD[5]   2s_ttl33_cin
AL9   2_TXD[0]   2s_ttl33_cio_r25
AL11   debug[15]   2s_ttl33_cio_d24
AL12   debug[10]   2s_ttl33_cio_d24
AL13   2_TX_ER   2s_ttl33_cio_d24
AL15   2_XCLK   2s_ttl33_cio_d24
AL20   vme_data[23]   2s_ttl33_cio_d24
AL21   3_TX_ER   2s_ttl33_cio_d24
AL22   address[17]   2s_ttl33_cin
AL23   dir_trans   2s_ttl33_cio_d24
AL24   3_RXD[14]   2s_ttl33_cin
AL25   3_RXD[9]   2s_ttl33_cin
AL26   3_TXD[5]   2s_ttl33_cio_r25
AL27   3_TXD[7]   2s_ttl33_cio_r25
AL28   3_TXD[13]   2s_ttl33_cio_r25
AL29   3_TXD[8]   2s_ttl33_cio_r25
AL30   nCONFIG   2s_ttl33_cin
AL31   TDI   2s_ttl33_cin
AL32   GND   GND
AM2   GND   GND
AM3   VCCIO7   POWER
AM4   2_RXD[6]   2s_ttl33_cin
AM5   2_RXD[4]   2s_ttl33_cin
AM6   2_RXD[9]   2s_ttl33_cin
AM7   2_RXD[8]   2s_ttl33_cin
AM8   2_RXD[13]   2s_ttl33_cin
AM9   2_TXD[13]   2s_ttl33_cio_r25
AM12   debug[6]   2s_ttl33_cio_d24
AM13   GND   GND
AM15   VCCIO7   POWER
AM18   VCCIO8   POWER
AM20   GND   GND
AM21   address[23]   2s_ttl33_cin
AM22   vme_data[24]   2s_ttl33_cio_d24
AM23   address[19]   2s_ttl33_cin
AM24   3_RXD[0]   2s_ttl33_cin
AM25   3_RX_ER   2s_ttl33_cio_d24
AM26   debug[18]   2s_ttl33_cio_d24
AM27   3_TXD[10]   2s_ttl33_cio_r25
AM28   3_TXD[1]   2s_ttl33_cio_r25
AM29   3_TXD[11]   2s_ttl33_cio_r25
AM30   VCCIO8   POWER
AM31   GND   GND
B1   GND   GND
B2   MSEL0   2s_ttl33_cin
B3   NC   NC
B6   1_RXD[4]   2s_ttl33_cin
B7   debug[2]   2s_ttl33_cio_d24
B8   1_RXD[9]   2s_ttl33_cin
B10   1_TXD[15]   2s_ttl33_cio_r25
B12   am[0]   2s_ttl33_cin
B13   _ga[4]   2s_ttl33_cin
B14   _ga[2]   2s_ttl33_cin
B15   JC_uW_LE   2s_ttl33_cio_d24
B20   vme_data[6]   2s_ttl33_cio_d24
B21   vme_data[15]   2s_ttl33_cio_d24
B22   address[14]   2s_ttl33_cin
B23   address[11]   2s_ttl33_cin
B24   address[10]   2s_ttl33_cin
B25   0_TXD[1]   2s_ttl33_cio_r25
B26   0_TXD[5]   2s_ttl33_cio_r25
B27   0_RXD[7]   2s_ttl33_cin
B28   _ds[1]   2s_ttl33_cin
B29   0_RXD[15]   2s_ttl33_cin
B30   nSTATUS   2s_ttl33_nstatus
B31   DCLK   2s_ttl33_dclk
B32   GND   GND
C1   VCCIO5   POWER
C2   VREFB4   POWER
C3   TDO   2s_ttl33_tdo
C5   1_RXD[1]   2s_ttl33_cin
C6   1_RX_CLK   2s_ttl33_cin
C7   1_RXD[13]   2s_ttl33_cin
C8   _iack   2s_ttl33_cin
C9   debug[4]   2s_ttl33_cio_d24
C10   1_TXD[12]   2s_ttl33_cio_r25
C11   1_TXD[0]   2s_ttl33_cio_r25
C13   1_RXD[0]   2s_ttl33_cin
C14   VREFB4   POWER
C15   JC_SYNCn   2s_ttl33_cio_d24
C16   ClockSwitchControl[1  2s_ttl33_cio_d24
C19   VREFB3   POWER
C20   vme_data[7]   2s_ttl33_cio_d24
C21   vme_data[2]   2s_ttl33_cio_d24
C22   address[13]   2s_ttl33_cin
C23   address[9]   2s_ttl33_cin
C24   address[5]   2s_ttl33_cin
C25   0_TXD[9]   2s_ttl33_cio_r25
C26   0_TXD[4]   2s_ttl33_cio_r25
C27   debug[14]   2s_ttl33_cio_d24
C28   0_RXD[6]   2s_ttl33_cin
C29   0_RX_DV   2s_ttl33_cio_d24
C30   nCE   2s_ttl33_cin
C31   VREFB3   POWER
C32   VCCIO2   POWER
D1   DigIn_AUX   2s_lvds25_rin_t100
D2   DigIn_AUX(n)   2s_lvds25_rin_t100
D5   1_RXD[10]   2s_ttl33_cin
D6   debug[8]   2s_ttl33_cio_d24
D7   _berr   2s_ttl33_cio_d24
D8   1_TXD[8]   2s_ttl33_cio_r25
D9   VREFB4   POWER
D10   1_TXD[2]   2s_ttl33_cio_r25
D11   1_TXD[11]   2s_ttl33_cio_r25
D13   _ga[0]   2s_ttl33_cin
D14   1_RXD[5]   2s_ttl33_cin
D15   JC_uW_DATA   2s_ttl33_cio_d24
D16   JC_uW_CLK   2s_ttl33_cio_d24
D19   vme_data[8]   2s_ttl33_cio_d24
D20   vme_data[5]   2s_ttl33_cio_d24
D21   0_LCKREFN   2s_ttl33_cio_d24
D22   0_TX_EN   2s_ttl33_cio_d24
D23   0_TX_ER   2s_ttl33_cio_d24
D24   VREFB3   POWER
D25   0_TXD[13]   2s_ttl33_cio_r25
D26   0_TXD[15]   2s_ttl33_cio_r25
D27   0_RXD[9]   2s_ttl33_cin
D28   0_RXD[1]   2s_ttl33_cin
E1   DigIn[1]   2s_lvds25_rin_t100
E2   DigIn[1](n)   2s_lvds25_rin_t100
E3   DigIn[0]   2s_lvds25_rin_t100
E4   DigIn[0](n)   2s_lvds25_rin_t100
E5   1_RXD[7]   2s_ttl33_cin
E6   1_RX_ER   2s_ttl33_cio_d24
E7   1_RX_DV   2s_ttl33_cio_d24
E8   1_TXD[9]   2s_ttl33_cio_r25
E9   1_TXD[1]   2s_ttl33_cio_r25
E10   GND   GND
E11   1_RXD[12]   2s_ttl33_cin
E12   VCCIO4   POWER
E13   am[5]   2s_ttl33_cin
E14   1_RXD[3]   2s_ttl33_cin
E15   ClockSwitchControl[0  2s_ttl33_cio_d24
E16   JC_LD   2s_ttl33_cio_d24
E19   vme_data[11]   2s_ttl33_cio_d24
E20   vme_data[3]   2s_ttl33_cio_d24
E21   VCCIO3   POWER
E22   address[3]   2s_ttl33_cin
E23   GND   GND
E24   0_TXD[8]   2s_ttl33_cio_r25
E25   0_TXD[6]   2s_ttl33_cio_r25
E26   0_RXD[3]   2s_ttl33_cin
E27   0_TXD[0]   2s_ttl33_cio_r25
E28   0_RXD[8]   2s_ttl33_cin
F5   VREFB5   POWER
F6   MSEL1   2s_ttl33_cin
F7   GND   GND
F8   1_TXD[3]   2s_ttl33_cio_r25
F9   1_TXD[13]   2s_ttl33_cio_r25
F10   1_TXD[4]   2s_ttl33_cio_r25
F11   am[2]   2s_ttl33_cin
F12   1_RXD[14]   2s_ttl33_cin
F13   am[4]   2s_ttl33_cin
F14   led_2   2s_ttl33_cio_d24
F15   JC_GOE   2s_ttl33_cio_d24
F16   clkswitch_Local   2s_ttl33_cin
F19   _ds[0]   2s_ttl33_cin
F20   vme_data[0]   2s_ttl33_cio_d24
F21   ~CONFIGURE_AS_INPUT_  2s_ttl33_cin
F22   address[6]   2s_ttl33_cin
F23   address[4]   2s_ttl33_cin
F24   0_RXD[4]   2s_ttl33_cin
F25   ~CONFIGURE_AS_INPUT_  2s_ttl33_cin
F26   NC   NC
F27   GND   GND
F28   VREFB2   POWER
G7   NC   NC
G8   NC   NC
G9   NC   NC
G12   1_RXD[2]   2s_ttl33_cin
G13   _lword   2s_ttl33_cin
G14   ~CONFIGURE_AS_INPUT_  2s_ttl33_cin
G15   VCCA_PLL5   POWER
G16   NC   NC
G17   GND   GND
G18   NC   NC
G19   vme_data[1]   2s_ttl33_cio_d24
G21   0_RXD[0]   2s_ttl33_cin
G22   debug[12]   2s_ttl33_cio_d24
G23   address[8]   2s_ttl33_cin
G24   0_RX_CLK   2s_ttl33_cin
G25   0_RXD[5]   2s_ttl33_cin
G26   NC   NC
H5   ~CONFIGURE_AS_INPUT_  2s_ttl25_rtin
H6   ~CONFIGURE_AS_INPUT_  2s_ttl25_rtin
H7   VCCD_PLL10   POWER
H8   VCCA_PLL10   POWER
H9   ~CONFIGURE_AS_INPUT_  2s_ttl33_cin
H10   MSEL3   2s_ttl33_cin
H14   1_TXD[6]   2s_ttl33_cio_r25
H15   VCCD_PLL5   POWER
H16   NC   NC
H17   VCCA_PLL11   POWER
H18   NC   NC
H19   ~DATA0~   2s_ttl33_cin
H20   address[15]   2s_ttl33_cin
H21   0_TXD[3]   2s_ttl33_cio_r25
H23   0_RXD[14]   2s_ttl33_cin
H24   0_RX_ER   2s_ttl33_cio_d24
H25   VCCD_PLL7   POWER
H26   VCCA_PLL7   POWER
H27   DigOutput_AUX2(n)   2s_lvds25_ro
H28   DigOutput_AUX2   2s_lvds25_ro
J5   VREFB5   POWER
J8   1st_outputbus[15]   2s_lvds25_ro
J9   1st_outputbus[15](n)  2s_lvds25_ro
J10   MSEL2   2s_ttl33_cin
J13   1_TXD[7]   2s_ttl33_cio_r25
J16   VCC_PLL5_OUT   POWER
J17   VCC_PLL11_OUT   POWER
J18   VCCD_PLL11   POWER
J19   address[12]   2s_ttl33_cin
J20   _dtack   2s_ttl33_cio_d24
J21   0_TXD[12]   2s_ttl33_cio_r25
J22   0_RXD[10]   2s_ttl33_cin
J24   GND   GND
J25   CONF_DONE   2s_ttl33_cfdone
J26   DigOutput_AUX3(n)   2s_lvds25_ro
J27   DigOutput_AUX3   2s_lvds25_ro
J28   VREFB2   POWER
K5   GND   GND
K6   1st_outputbus[11]   2s_lvds25_ro
K7   1st_outputbus[11](n)  2s_lvds25_ro
K8   1st_outputbus[14]   2s_lvds25_ro
K9   1st_outputbus[14](n)  2s_lvds25_ro
K10   VCCINT   POWER
K11   led_1   2s_ttl33_cio_d24
K13   1_TXD[5]   2s_ttl33_cio_r25
K15   _ga[1]   2s_ttl33_cin
K16   1_LCKREFN   2s_ttl33_cio_d24
K17   1_TX_EN   2s_ttl33_cio_d24
K18   vme_data[4]   2s_ttl33_cio_d24
K19   vme_data[14]   2s_ttl33_cio_d24
K20   address[7]   2s_ttl33_cin
K21   0_TXD[14]   2s_ttl33_cio_r25
K22   0_RXD[2]   2s_ttl33_cin
K23   VCCINT   POWER
K24   DigOutput(n)   2s_lvds25_ro
K25   DigOutput   2s_lvds25_ro
K26   Debug_LVDS_OUT_0(n)   2s_lvds25_ro
K27   Debug_LVDS_OUT_0   2s_lvds25_ro
K28   GND   GND
L5   1st_outputbus[10]   2s_lvds25_ro
L6   1st_outputbus[10](n)  2s_lvds25_ro
L7   1st_outputbus[12]   2s_lvds25_ro
L8   1st_outputbus[12](n)  2s_lvds25_ro
L9   1st_outputbus[13]   2s_lvds25_ro
L10   1st_outputbus[13](n)  2s_lvds25_ro
L11   GND   GND
L12   led_0   2s_ttl33_cio_d24
L13   1_TXD[10]   2s_ttl33_cio_r25
L14   1_RXD[15]   2s_ttl33_cin
L15   am[3]   2s_ttl33_cin
L16   ClockSwitchControl[2  2s_ttl33_cio_d24
L17   _ga[3]   2s_ttl33_cin
L18   vme_data[12]   2s_ttl33_cio_d24
L19   vme_data[13]   2s_ttl33_cio_d24
L20   0_TXD[2]   2s_ttl33_cio_r25
L21   0_RXD[13]   2s_ttl33_cin
L22   0_ENABLE   2s_ttl33_cio_d24
L23   DigOutput_AUX1(n)   2s_lvds25_ro
L24   DigOutput_AUX1   2s_lvds25_ro
L27   ~CONFIGURE_AS_INPUT_  2s_ttl25_rtin
L28   ~CONFIGURE_AS_INPUT_  2s_ttl25_rtin
M5   VCCIO5   POWER
M6   1st_outputbus[7]   2s_lvds25_ro
M7   1st_outputbus[7](n)   2s_lvds25_ro
M8   1st_outputbus[8]   2s_lvds25_ro
M9   1st_outputbus[8](n)   2s_lvds25_ro
M10   1st_outputbus[9]   2s_lvds25_ro
M11   1st_outputbus[9](n)   2s_lvds25_ro
M12   GND   GND
M13   VCCPD4   POWER
M14   GND   GND
M15   VCCPD4   POWER
M16   VCCIO4   POWER
M17   VCCIO3   POWER
M18   VCCPD3   POWER
M19   GND   GND
M20   VCCPD3   POWER
M21   VCCINT   POWER
M22   Debug_LVDS_OUT_1(n)   2s_lvds25_ro
M23   Debug_LVDS_OUT_1   2s_lvds25_ro
M28   VCCIO2   POWER
N1   GND   GND
N6   1st_outputbus[6]   2s_lvds25_ro
N7   1st_outputbus[6](n)   2s_lvds25_ro
N8   1st_outputbus[5]   2s_lvds25_ro
N9   1st_outputbus[5](n)   2s_lvds25_ro
N12   VCCPD5   POWER
N13   VCCINT   POWER
N14   GND   GND
N15   VCCINT   POWER
N16   GND   GND
N17   VCCINT   POWER
N18   GND   GND
N19   VCCINT   POWER
N20   GND   GND
N21   VCCPD2   POWER
N32   GND   GND
P3   VREFB5   POWER
P4   1st_outputbus[2]   2s_lvds25_ro
P5   1st_outputbus[2](n)   2s_lvds25_ro
P6   1st_outputbus[3]   2s_lvds25_ro
P7   1st_outputbus[3](n)   2s_lvds25_ro
P8   1st_outputbus[4]   2s_lvds25_ro
P9   1st_outputbus[4](n)   2s_lvds25_ro
P10   1st_outputbus[1]   2s_lvds25_ro
P11   1st_outputbus[1](n)   2s_lvds25_ro
P12   GND   GND
P13   GND   GND
P14   VCCINT   POWER
P15   GND   GND
P16   VCCINT   POWER
P17   GND   GND
P18   VCCINT   POWER
P19   GND   GND
P20   VCCINT   POWER
P21   GND   GND
P30   VREFB2   POWER
R1   VCCIO5   POWER
R4   2nd_outputbus[15]   2s_lvds25_ro
R5   2nd_outputbus[15](n)  2s_lvds25_ro
R6   1st_outputbus[0]   2s_lvds25_ro
R7   1st_outputbus[0](n)   2s_lvds25_ro
R8   NC   NC
R9   VCCA_PLL4   POWER
R10   2nd_outputbus[14]   2s_lvds25_ro
R11   2nd_outputbus[14](n)  2s_lvds25_ro
R12   VCCPD5   POWER
R13   VCCINT   POWER
R14   GND   GND
R15   VCCINT   POWER
R16   GND   GND
R17   VCCINT   POWER
R18   GND   GND
R19   VCCINT   POWER
R20   GND   GND
R21   VCCPD2   POWER
R32   VCCIO2   POWER
T1   master_clock3   2s_lvds25_rin
T2   master_clock3(n)   2s_lvds25_rin
T5   2nd_outputbus[13]   2s_lvds25_ro
T6   2nd_outputbus[13](n)  2s_lvds25_ro
T7   GND   GND
T8   NC   NC
T9   VCCD_PLL4   POWER
T10   2nd_outputbus[12]   2s_lvds25_ro
T11   2nd_outputbus[12](n)  2s_lvds25_ro
T12   VCCIO5   POWER
T13   GND   GND
T14   VCCINT   POWER
T15   GND   GND
T16   VCCINT   POWER
T17   GND   GND
T18   VCCINT   POWER
T19   GND   GND
T20   VCCINT   POWER
T21   VCCIO2   POWER
T24   VCCA_PLL1   POWER
T25   NC   NC
T26   NC   NC
U5   2nd_outputbus[11]   2s_lvds25_ro
U6   2nd_outputbus[11](n)  2s_lvds25_ro
U7   VCCD_PLL3   POWER
U8   NC   NC
U9   VCCA_PLL3   POWER
U10   2nd_outputbus[10]   2s_lvds25_ro
U11   2nd_outputbus[10](n)  2s_lvds25_ro
U12   VCCIO6   POWER
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[Diff Pin]  inv_pin  vdiff  tdelay_typ  tdelay_min  tdelay_max
AA30   AA29   0.4   NA   NA   NA
AA32   AA31   0.4   NA   NA   NA
AB5   AB6   NA   NA   NA   NA
AB28   AB27   0.4   NA   NA   NA
AB30   AB29   0.4   NA   NA   NA
AB32   AB31   0.4   NA   NA   NA
AC32   AC31   0.4   NA   NA   NA
AD32   AD31   0.4   NA   NA   NA
AE30   AE29   0.4   NA   NA   NA
AE32   AE31   0.4   NA   NA   NA
AF30   AF29   0.4   NA   NA   NA
AF32   AF31   0.4   NA   NA   NA
AG30   AG29   0.4   NA   NA   NA
AG32   AG31   0.4   NA   NA   NA
AH30   AH29   0.4   NA   NA   NA
AH32   AH31   0.4   NA   NA   NA
AJ32   AJ31   0.4   NA   NA   NA
D1   D2   0.4   NA   NA   NA
E1   E2   0.4   NA   NA   NA
E3   E4   0.4   NA   NA   NA
H28   H27   NA   NA   NA   NA
J8   J9   NA   NA   NA   NA
J27   J26   NA   NA   NA   NA
K6   K7   NA   NA   NA   NA
K8   K9   NA   NA   NA   NA
K25   K24   NA   NA   NA   NA
K27   K26   NA   NA   NA   NA
L5   L6   NA   NA   NA   NA
L7   L8   NA   NA   NA   NA
L9   L10   NA   NA   NA   NA
L24   L23   NA   NA   NA   NA
M6   M7   NA   NA   NA   NA
M8   M9   NA   NA   NA   NA
M10   M11   NA   NA   NA   NA
M23   M22   NA   NA   NA   NA
N6   N7   NA   NA   NA   NA
N8   N9   NA   NA   NA   NA
P4   P5   NA   NA   NA   NA
P6   P7   NA   NA   NA   NA
P8   P9   NA   NA   NA   NA
P10   P11   NA   NA   NA   NA
R4   R5   NA   NA   NA   NA
R6   R7   NA   NA   NA   NA
R10   R11   NA   NA   NA   NA
T1   T2   0.4   NA   NA   NA
T5   T6   NA   NA   NA   NA
T10   T11   NA   NA   NA   NA
U5   U6   NA   NA   NA   NA
U10   U11   NA   NA   NA   NA
U32   U31   0.4   NA   NA   NA
V4   V5   NA   NA   NA   NA
V6   V7   NA   NA   NA   NA
V9   V10   NA   NA   NA   NA
W4   W5   NA   NA   NA   NA
W6   W7   NA   NA   NA   NA
W8   W9   NA   NA   NA   NA
Y6   Y7   NA   NA   NA   NA
Y8   Y9   NA   NA   NA   NA
Y10   Y11   NA   NA   NA   NA
Y29   Y28   0.4   NA   NA   NA
Y31   Y30   0.4   NA   NA   NA
| Models and submodels in the file (13): 2s_ttl33_cin (Input), 2s_ttl33_cio_d24 (I/O), 2s_ttl33_cio_r25 (I/O), 2s_lvds25_rin_t100 (Input), 2s_lvds25_ro (3-state), 2s_ttl25_rrin (Input), 2s_ttl33_nceo (I/O), 2s_ttl33_nstatus (I/O_open_drain), 2s_ttl33_dclk (I/O), 2s_ttl33_tdo (Output), 2s_ttl25_rtin (Input), 2s_ttl33_cfdone (I/O_open_drain), 2s_lvds25_rin (Input)
