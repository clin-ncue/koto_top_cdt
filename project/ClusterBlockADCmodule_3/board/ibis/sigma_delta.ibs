[IBIS Ver] 3.2
[File Name] sigma_delta.ibs
[File Rev] 4.9
[Date] November 23, 2016
[Source] Altera, Quartus II 64-Bit 9.1
[Notes]
| The models are designated as "Final" and have been
| correlated against physical device operation.
Unused IOs which have been assigned as tri-stated inputs or
as outputs driving any signal in Quartus II are represented by the NC.
[Disclaimer] Data is for modeling purposes only and is not guaranteed.
[Copyright] Copyright (C) 1991-2010 Altera Corporation
[Component] EP2S60F1020C5_sigma_delta
[Manufacturer]  Altera Corporation
[Package]
| RLC values are for 1020 FBGA package
|variable  typ  min  max
R_pkg  156.00m   81.00m   770.00m
L_pkg  0.95nH   0.50nH   4.37nH
C_pkg  0.71pF   0.50pF   2.41pF
[Pin]  signal_name   model_name   R_pin   L_pin   C_pin
A2   GND   GND
A3   VCCIO4   POWER
A4   TH[77]   2s_ttl33_cin
A5   TH[64]   2s_ttl33_cin
A6   TH[74]   2s_ttl33_cin
A7   adcin[35]   2s_ttl33_cin
A8   adcin[38]   2s_ttl33_cin
A9   adcin[39]   2s_ttl33_cin
A10   TH[41]   2s_ttl33_cin
A13   GND   GND
A15   VCCIO4   POWER
A16   TH[190]   2s_ttl33_cin
A17   TH[63]   2s_ttl33_cin
A18   VCCIO3   POWER
A20   GND   GND
A27   TH[168]   2s_ttl33_cin
A28   TH[160]   2s_ttl33_cin
A29   TH[163]   2s_ttl33_cin
A30   VCCIO3   POWER
A31   GND   GND
AA1   adcin[198]   2s_ttl33_rrin
AA2   adcin[197]   2s_ttl33_rrin
AA3   adcin[208]   2s_ttl33_rrin
AA4   adcin[204]   2s_ttl33_rrin
AA5   VCCIO6   POWER
AA6   adcin[0]   2s_ttl33_rtin
AA7   adcin[4]   2s_ttl33_rtin
AA8   TH[8]   2s_ttl33_rtin
AA9   TH[4]   2s_ttl33_rtin
AA10   adcin[5]   2s_ttl33_rtin
AA11   adcin[7]   2s_ttl33_rtin
AA12   VCCINT   POWER
AA13   VCCPD7   POWER
AA14   GND   GND
AA15   VCCPD7   POWER
AA16   VCCIO7   POWER
AA17   VCCIO8   POWER
AA18   VCCPD8   POWER
AA19   GND   GND
AA20   VCCPD8   POWER
AA21   GND   GND
AA22   adcin[109]   2s_ttl33_rtin
AA23   adcin[100]   2s_ttl33_rtin
AA24   adcin[98]   2s_ttl33_rtin
AA25   adcin[111]   2s_ttl33_rtin
AA27   TH[192]   2s_ttl33_rtin
AA28   VCCIO1   POWER
AA29   adcin[173]   2s_ttl33_rrin
AA30   adcin[175]   2s_ttl33_rrin
AA31   adcin[177]   2s_ttl33_rrin
AA32   TH[193]   2s_ttl33_rrin
AB1   TH[228]   2s_ttl33_rrin
AB2   adcin[206]   2s_ttl33_rrin
AB3   TH[235]   2s_ttl33_rrin
AB4   TH[237]   2s_ttl33_rrin
AB5   adcin[11]   2s_ttl33_rtin
AB6   adcin[12]   2s_ttl33_rtin
AB7   adcin[136]   2s_ttl33_rtin
AB8   adcin[130]   2s_ttl33_rtin
AB9   adcin[127]   2s_ttl33_rtin
AB10   adcin[138]   2s_ttl33_rtin
AB11   TH[152]   2s_ttl33_cin
AB12   TH[87]   2s_ttl33_cin
AB15   AlignData[5]   2s_ttl33_cin
AB16   AlignData[1]   2s_ttl33_cin
AB22   GND   GND
AB23   adcin[163]   2s_ttl33_rtin
AB24   adcin[158]   2s_ttl33_rtin
AB25   adcin[104]   2s_ttl33_rtin
AB26   adcin[103]   2s_ttl33_rtin
AB27   TH[191]   2s_ttl33_rrin
AB28   TH[158]   2s_ttl33_rrin
AB29   TH[195]   2s_ttl33_rrin
AB30   TH[198]   2s_ttl33_rrin
AB31   adcin[168]   2s_ttl33_rrin
AB32   adcin[170]   2s_ttl33_rrin
AC1   TH[62]   2s_ttl33_rrin
AC2   TH[234]   2s_ttl33_rrin
AC3   TH[13]   2s_ttl33_rrin
AC4   TH[1]   2s_ttl33_rrin
AC5   GND   GND
AC6   adcin[135]   2s_ttl33_rtin
AC7   TH[146]   2s_ttl33_rtin
AC8   adcin[131]   2s_ttl33_rtin
AC9   adcin[133]   2s_ttl33_rtin
AC10   VCCINT   POWER
AC11   TH[82]   2s_ttl33_cin
AC12   adcin[77]   2s_ttl33_cin
AC15   InputBIT_5   2s_ttl33_cin
AC16   TapDelaySelect[0]   2s_ttl33_cin
AC22   TH[179]   2s_ttl33_cin
AC23   VCCSEL   2s_ttl33_cin
AC24   TH[119]   2s_ttl33_rtin
AC25   TH[123]   2s_ttl33_rtin
AC26   TH[120]   2s_ttl33_rtin
AC27   adcin[107]   2s_ttl33_rtin
AC28   GND   GND
AC29   NC   NC
AC30   NC   NC
AC31   TH[201]   2s_ttl33_rrin
AC32   TH[196]   2s_ttl33_rrin
AD1   adcin[3]   2s_ttl33_rrin
AD2   adcin[1]   2s_ttl33_rrin
AD3   NC   NC
AD4   NC   NC
AD5   VREFB6   POWER
AD6   TH[11]   2s_ttl33_rtin
AD7   TH[12]   2s_ttl33_rtin
AD8   TH[157]   2s_ttl33_rtin
AD9   TH[155]   2s_ttl33_rtin
AD10   TH[145]   2s_ttl33_cin
AD11   adcin[70]   2s_ttl33_cin
AD12   adcin[76]   2s_ttl33_cin
AD15   VCCD_PLL6   POWER
AD16   NC   NC
AD17   NC   NC
AD19   TH[127]   2s_ttl33_cin
AD22   TH[125]   2s_ttl33_cin
AD23   TH[178]   2s_ttl33_cin
AD24   adcin[166]   2s_ttl33_rtin
AD25   adcin[155]   2s_ttl33_rtin
AD26   TH[124]   2s_ttl33_rtin
AD27   TH[121]   2s_ttl33_rtin
AD28   VREFB1   POWER
AD29   NC   NC
AD30   NC   NC
AD31   TH[115]   2s_ttl33_rrin
AD32   TH[122]   2s_ttl33_rrin
AE1   adcin[13]   2s_ttl33_rrin
AE2   adcin[2]   2s_ttl33_rrin
AE3   adcin[6]   2s_ttl33_rrin
AE4   TH[7]   2s_ttl33_rrin
AE5   NC   NC
AE6   NC   NC
AE7   VCCA_PLL9   POWER
AE8   VCCD_PLL9   POWER
AE9   NC   NC
AE10   TH[88]   2s_ttl33_cin
AE11   TH[80]   2s_ttl33_cin
AE12   TH[92]   2s_ttl33_cin
AE13   TH[159]   2s_ttl33_cin
AE15   VCCA_PLL6   POWER
AE16   NC   NC
AE17   NC   NC
AE18   VCCD_PLL12   POWER
AE22   TH[188]   2s_ttl33_cin
AE23   TH[187]   2s_ttl33_cin
AE24   TMS   2s_ttl33_cin
AE25   TH[181]   2s_ttl33_rtin
AE26   adcin[161]   2s_ttl33_rtin
AE27   adcin[162]   2s_ttl33_rtin
AE28   adcin[164]   2s_ttl33_rtin
AE29   adcin[99]   2s_ttl33_rrin
AE30   adcin[110]   2s_ttl33_rrin
AE31   TH[114]   2s_ttl33_rrin
AE32   TH[112]   2s_ttl33_rrin
AF1   adcin[8]   2s_ttl33_rrin
AF2   adcin[10]   2s_ttl33_rrin
AF3   TH[6]   2s_ttl33_rrin
AF4   TH[5]   2s_ttl33_rrin
AF5   NC   NC
AF6   NC   NC
AF7   NC   NC
AF9   GND   GND
AF10   TH[86]   2s_ttl33_cin
AF14   NC   NC
AF15   VCC_PLL6_OUT   POWER
AF16   VCC_PLL12_OUT   POWER
AF17   GND   GND
AF18   VCCA_PLL12   POWER
AF21   TH[184]   2s_ttl33_cin
AF22   TH[177]   2s_ttl33_cin
AF23   TH[186]   2s_ttl33_cin
AF24   TCK   2s_ttl33_cin
AF25   VCCD_PLL8   POWER
AF26   VCCA_PLL8   POWER
AF27   NC   NC
AF28   NC   NC
AF29   adcin[105]   2s_ttl33_rrin
AF30   TH[118]   2s_ttl33_rrin
AF31   adcin[108]   2s_ttl33_rrin
AF32   adcin[101]   2s_ttl33_rrin
AG1   TH[3]   2s_ttl33_rrin
AG2   TH[10]   2s_ttl33_rrin
AG3   TH[154]   2s_ttl33_rrin
AG4   TH[156]   2s_ttl33_rrin
AG5   VREFB6   POWER
AG6   GND   GND
AG7   NC   NC
AG16   InputBIT_4   2s_ttl33_cin
AG21   NC   NC
AG25   NC   NC
AG26   NC   NC
AG27   NC   NC
AG28   VREFB1   POWER
AG29   adcin[165]   2s_ttl33_rrin
AG30   adcin[156]   2s_ttl33_rrin
AG31   adcin[102]   2s_ttl33_rrin
AG32   adcin[106]   2s_ttl33_rrin
AH1   adcin[129]   2s_ttl33_rrin
AH2   adcin[134]   2s_ttl33_rrin
AH3   adcin[126]   2s_ttl33_rrin
AH4   adcin[139]   2s_ttl33_rrin
AH5   TH[147]   2s_ttl33_cin
AH9   TH[81]   2s_ttl33_cin
AH10   GND   GND
AH12   VCCIO7   POWER
AH15   AlignData[0]   2s_ttl33_cin
AH16   AlignData[4]   2s_ttl33_cin
AH21   VCCIO8   POWER
AH23   GND   GND
AH27   GND   GND
AH28   TH[189]   2s_ttl33_cin
AH29   adcin[159]   2s_ttl33_rrin
AH30   adcin[160]   2s_ttl33_rrin
AH31   TH[176]   2s_ttl33_rrin
AH32   TH[117]   2s_ttl33_rrin
AJ1   TH[151]   2s_ttl33_rrin
AJ2   adcin[132]   2s_ttl33_rrin
AJ3   adcin[137]   2s_ttl33_rrin
AJ4   TH[153]   2s_ttl33_rrin
AJ5   TH[150]   2s_ttl33_cin
AJ6   TH[90]   2s_ttl33_cin
AJ7   adcin[78]   2s_ttl33_cin
AJ8   adcin[80]   2s_ttl33_cin
AJ9   VREFB7   POWER
AJ10   adcin[73]   2s_ttl33_cin
AJ15   Trigger   2s_ttl33_cin
AJ16   TapDelaySelect[2]   2s_ttl33_cin
AJ17   InputBIT_6   2s_ttl33_cin
AJ18   AlignData[3]   2s_ttl33_cin
AJ24   VREFB8   POWER
AJ27   TH[143]   2s_ttl33_cin
AJ28   TH[110]   2s_ttl33_cin
AJ29   TH[183]   2s_ttl33_rrin
AJ30   adcin[157]   2s_ttl33_rrin
AJ31   adcin[167]   2s_ttl33_rrin
AJ32   adcin[154]   2s_ttl33_rrin
AK1   VCCIO6   POWER
AK2   VREFB7   POWER
AK3   nIO_PULLUP   2s_ttl33_cin
AK4   TH[149]   2s_ttl33_cin
AK5   TH[144]   2s_ttl33_cin
AK6   TH[91]   2s_ttl33_cin
AK7   adcin[81]   2s_ttl33_cin
AK8   TH[83]   2s_ttl33_cin
AK9   adcin[79]   2s_ttl33_cin
AK10   TH[255]   2s_ttl33_cin
AK14   VREFB7   POWER
AK15   AlignData[2]   2s_ttl33_cin
AK16   TapDelaySelect[3]   2s_ttl33_cin
AK17   master_clock1   2s_ttl33_cin
AK18   clkswitch   2s_ttl33_cin
AK19   VREFB8   POWER
AK28   TH[182]   2s_ttl33_cin
AK29   TH[185]   2s_ttl33_cin
AK30   TRST   2s_ttl33_cin
AK31   VREFB8   POWER
AK32   VCCIO1   POWER
AL1   GND   GND
AL2   PORSEL   2s_ttl33_cin
AL3   nCEO   2s_ttl33_nceo
AL4   adcin[128]   2s_ttl33_cin
AL5   TH[89]   2s_ttl33_cin
AL6   adcin[72]   2s_ttl33_cin
AL7   adcin[82]   2s_ttl33_cin
AL8   adcin[75]   2s_ttl33_cin
AL9   TH[93]   2s_ttl33_cin
AL13   AlignData[6]   2s_ttl33_cin
AL15   TapDelaySelect[1]   2s_ttl33_cin
AL16   Tx_Sel   2s_ttl33_cin
AL28   TH[239]   2s_ttl33_cin
AL29   TH[180]   2s_ttl33_cin
AL30   nCONFIG   2s_ttl33_cin
AL31   TDI   2s_ttl33_cin
AL32   GND   GND
AM2   GND   GND
AM3   VCCIO7   POWER
AM4   TH[148]   2s_ttl33_cin
AM5   adcin[74]   2s_ttl33_cin
AM6   adcin[71]   2s_ttl33_cin
AM7   adcin[83]   2s_ttl33_cin
AM8   TH[85]   2s_ttl33_cin
AM9   TH[84]   2s_ttl33_cin
AM13   GND   GND
AM15   VCCIO7   POWER
AM16   AlignData[7]   2s_ttl33_cin
AM18   VCCIO8   POWER
AM20   GND   GND
AM21   TH[206]   2s_ttl33_cin
AM24   TH[126]   2s_ttl33_cin
AM27   TH[30]   2s_ttl33_cin
AM28   TH[254]   2s_ttl33_cin
AM29   TH[111]   2s_ttl33_cin
AM30   VCCIO8   POWER
AM31   GND   GND
B1   GND   GND
B2   MSEL0   2s_ttl33_cin
B3   NC   NC
B4   adcin[56]   2s_ttl33_cin
B5   TH[66]   2s_ttl33_cin
B6   TH[73]   2s_ttl33_cin
B7   TH[37]   2s_ttl33_cin
B8   adcin[40]   2s_ttl33_cin
B9   adcin[29]   2s_ttl33_cin
B10   TH[34]   2s_ttl33_cin
B11   TH[79]   2s_ttl33_cin
B27   TH[164]   2s_ttl33_cin
B28   TH[28]   2s_ttl33_cin
B29   TH[173]   2s_ttl33_cin
B30   nSTATUS   2s_ttl33_nstatus
B31   DCLK   2s_ttl33_dclk
B32   GND   GND
C1   VCCIO5   POWER
C2   VREFB4   POWER
C3   TDO   2s_ttl33_tdo
C4   adcin[58]   2s_ttl33_cin
C5   TH[76]   2s_ttl33_cin
C6   TH[67]   2s_ttl33_cin
C7   TH[39]   2s_ttl33_cin
C8   adcin[36]   2s_ttl33_cin
C9   adcin[41]   2s_ttl33_cin
C10   TH[43]   2s_ttl33_cin
C11   TH[174]   2s_ttl33_cin
C14   VREFB4   POWER
C15   TH[238]   2s_ttl33_cin
C19   VREFB3   POWER
C27   TH[27]   2s_ttl33_cin
C28   TH[170]   2s_ttl33_cin
C29   TH[23]   2s_ttl33_cin
C30   nCE   2s_ttl33_cin
C31   VREFB3   POWER
C32   VCCIO2   POWER
D1   adcin[59]   2s_ttl33_rrin
D2   adcin[68]   2s_ttl33_rrin
D3   TH[70]   2s_ttl33_rrin
D4   adcin[60]   2s_ttl33_rrin
D5   adcin[67]   2s_ttl33_cin
D6   TH[68]   2s_ttl33_cin
D8   adcin[37]   2s_ttl33_cin
D9   VREFB4   POWER
D10   TH[45]   2s_ttl33_cin
D11   TH[32]   2s_ttl33_cin
D16   TH[222]   2s_ttl33_cin
D19   TH[14]   2s_ttl33_cin
D24   VREFB3   POWER
D27   TH[162]   2s_ttl33_cin
D28   TH[161]   2s_ttl33_cin
D29   adcin[19]   2s_ttl33_rrin
D30   adcin[21]   2s_ttl33_rrin
D31   adcin[141]   2s_ttl33_rrin
D32   adcin[153]   2s_ttl33_rrin
E1   TH[253]   2s_ttl33_rrin
E2   TH[249]   2s_ttl33_rrin
E3   adcin[63]   2s_ttl33_rrin
E4   adcin[62]   2s_ttl33_rrin
E5   adcin[64]   2s_ttl33_cin
E6   TH[42]   2s_ttl33_cin
E8   TH[38]   2s_ttl33_cin
E9   TH[35]   2s_ttl33_cin
E10   GND   GND
E12   VCCIO4   POWER
E17   TH[47]   2s_ttl33_cin
E21   VCCIO3   POWER
E23   GND   GND
E25   TH[20]   2s_ttl33_cin
E28   TH[21]   2s_ttl33_cin
E29   adcin[27]   2s_ttl33_rrin
E30   adcin[26]   2s_ttl33_rrin
E31   adcin[17]   2s_ttl33_rrin
E32   TH[26]   2s_ttl33_rrin
F1   adcin[215]   2s_ttl33_rrin
F2   adcin[216]   2s_ttl33_rrin
F3   TH[247]   2s_ttl33_rrin
F4   TH[242]   2s_ttl33_rrin
F5   VREFB5   POWER
F6   MSEL1   2s_ttl33_cin
F7   GND   GND
F8   adcin[32]   2s_ttl33_cin
F9   adcin[31]   2s_ttl33_cin
F10   TH[44]   2s_ttl33_cin
F11   TH[223]   2s_ttl33_cin
F13   TH[207]   2s_ttl33_cin
F21   NC   NC
F22   TH[78]   2s_ttl33_cin
F24   adcin[25]   2s_ttl33_cin
F25   NC   NC
F26   NC   NC
F27   GND   GND
F28   VREFB2   POWER
F29   adcin[145]   2s_ttl33_rrin
F30   TH[167]   2s_ttl33_rrin
F31   TH[165]   2s_ttl33_rrin
F32   TH[172]   2s_ttl33_rrin
G1   adcin[223]   2s_ttl33_rrin
G2   adcin[211]   2s_ttl33_rrin
G3   TH[252]   2s_ttl33_rrin
G4   adcin[221]   2s_ttl33_rrin
G5   NC   NC
G6   NC   NC
G7   NC   NC
G8   NC   NC
G9   NC   NC
G14   NC   NC
G15   VCCA_PLL5   POWER
G16   NC   NC
G17   GND   GND
G18   NC   NC
G22   TH[22]   2s_ttl33_cin
G23   adcin[149]   2s_ttl33_cin
G24   adcin[140]   2s_ttl33_cin
G25   adcin[148]   2s_ttl33_cin
G26   NC   NC
G27   NC   NC
G28   NC   NC
G29   adcin[151]   2s_ttl33_rrin
G30   adcin[18]   2s_ttl33_rrin
G31   TH[218]   2s_ttl33_rrin
G32   TH[216]   2s_ttl33_rrin
H1   TH[243]   2s_ttl33_rrin
H2   TH[250]   2s_ttl33_rrin
H3   NC   NC
H4   NC   NC
H5   NC   NC
H6   NC   NC
H7   VCCD_PLL10   POWER
H8   VCCA_PLL10   POWER
H9   NC   NC
H10   MSEL3   2s_ttl33_cin
H11   TH[75]   2s_ttl33_cin
H12   TH[65]   2s_ttl33_cin
H13   adcin[28]   2s_ttl33_cin
H14   TH[33]   2s_ttl33_cin
H15   VCCD_PLL5   POWER
H16   NC   NC
H17   VCCA_PLL11   POWER
H18   NC   NC
H19   ~DATA0~   2s_ttl33_cin
H22   TH[25]   2s_ttl33_cin
H23   TH[19]   2s_ttl33_cin
H24   adcin[150]   2s_ttl33_cin
H25   VCCD_PLL7   POWER
H26   VCCA_PLL7   POWER
H27   adcin[142]   2s_ttl33_rtin
H28   adcin[152]   2s_ttl33_rtin
H29   TH[169]   2s_ttl33_rrin
H30   adcin[144]   2s_ttl33_rrin
H31   TH[215]   2s_ttl33_rrin
H32   TH[214]   2s_ttl33_rrin
J1   TH[48]   2s_ttl33_rrin
J2   TH[49]   2s_ttl33_rrin
J3   adcin[213]   2s_ttl33_rrin
J4   adcin[218]   2s_ttl33_rrin
J5   VREFB5   POWER
J6   adcin[66]   2s_ttl33_rtin
J7   TH[72]   2s_ttl33_rtin
J8   adcin[69]   2s_ttl33_rtin
J9   adcin[57]   2s_ttl33_rtin
J10   MSEL2   2s_ttl33_cin
J11   adcin[33]   2s_ttl33_cin
J12   adcin[34]   2s_ttl33_cin
J13   TH[40]   2s_ttl33_cin
J16   VCC_PLL5_OUT   POWER
J17   VCC_PLL11_OUT   POWER
J18   VCCD_PLL11   POWER
J22   TH[17]   2s_ttl33_cin
J23   TH[16]   2s_ttl33_cin
J24   GND   GND
J25   CONF_DONE   2s_ttl33_cfdone
J26   adcin[14]   2s_ttl33_rtin
J27   adcin[16]   2s_ttl33_rtin
J28   VREFB2   POWER
J29   NC   NC
J30   NC   NC
J31   adcin[185]   2s_ttl33_rrin
J32   TH[213]   2s_ttl33_rrin
K1   adcin[43]   2s_ttl33_rrin
K2   adcin[45]   2s_ttl33_rrin
K3   TH[59]   2s_ttl33_rrin
K4   TH[58]   2s_ttl33_rrin
K5   GND   GND
K6   TH[245]   2s_ttl33_rtin
K7   adcin[217]   2s_ttl33_rtin
K8   TH[69]   2s_ttl33_rtin
K9   adcin[61]   2s_ttl33_rtin
K10   VCCINT   POWER
K11   TH[71]   2s_ttl33_cin
K12   adcin[30]   2s_ttl33_cin
K16   TH[175]   2s_ttl33_cin
K22   TH[24]   2s_ttl33_cin
K23   VCCINT   POWER
K24   adcin[15]   2s_ttl33_rtin
K25   adcin[20]   2s_ttl33_rtin
K26   adcin[24]   2s_ttl33_rtin
K27   adcin[22]   2s_ttl33_rtin
K28   GND   GND
K29   adcin[188]   2s_ttl33_rrin
K30   adcin[187]   2s_ttl33_rrin
K31   adcin[194]   2s_ttl33_rrin
K32   adcin[195]   2s_ttl33_rrin
L1   TH[61]   2s_ttl33_rrin
L2   TH[56]   2s_ttl33_rrin
L3   adcin[44]   2s_ttl33_rrin
L4   adcin[42]   2s_ttl33_rrin
L5   adcin[212]   2s_ttl33_rtin
L6   adcin[220]   2s_ttl33_rtin
L7   TH[246]   2s_ttl33_rtin
L8   TH[241]   2s_ttl33_rtin
L9   TH[248]   2s_ttl33_rtin
L10   TH[244]   2s_ttl33_rtin
L11   GND   GND
L12   adcin[65]   2s_ttl33_cin
L13   TH[36]   2s_ttl33_cin
L16   TH[46]   2s_ttl33_cin
L17   TH[142]   2s_ttl33_cin
L22   TH[18]   2s_ttl33_cin
L23   adcin[146]   2s_ttl33_rtin
L24   adcin[147]   2s_ttl33_rtin
L25   adcin[23]   2s_ttl33_rtin
L26   TH[29]   2s_ttl33_rtin
L27   NC   NC
L28   NC   NC
L29   adcin[183]   2s_ttl33_rrin
L30   adcin[182]   2s_ttl33_rrin
L31   TH[137]   2s_ttl33_rrin
L32   TH[130]   2s_ttl33_rrin
M1   adcin[95]   2s_ttl33_rrin
M2   TH[101]   2s_ttl33_rrin
M3   adcin[50]   2s_ttl33_rrin
M4   adcin[52]   2s_ttl33_rrin
M5   VCCIO5   POWER
M6   TH[251]   2s_ttl33_rtin
M7   TH[240]   2s_ttl33_rtin
M8   adcin[214]   2s_ttl33_rtin
M9   adcin[219]   2s_ttl33_rtin
M10   adcin[210]   2s_ttl33_rtin
M11   adcin[222]   2s_ttl33_rtin
M12   GND   GND
M13   VCCPD4   POWER
M14   GND   GND
M15   VCCPD4   POWER
M16   VCCIO4   POWER
M17   VCCIO3   POWER
M18   VCCPD3   POWER
M19   GND   GND
M20   VCCPD3   POWER
M21   VCCINT   POWER
M22   TH[171]   2s_ttl33_rtin
M23   adcin[143]   2s_ttl33_rtin
M24   TH[15]   2s_ttl33_rtin
M25   TH[166]   2s_ttl33_rtin
M26   TH[210]   2s_ttl33_rtin
M27   TH[209]   2s_ttl33_rtin
M28   VCCIO2   POWER
M30   TH[212]   2s_ttl33_rrin
M31   adcin[116]   2s_ttl33_rrin
M32   adcin[122]   2s_ttl33_rrin
N1   GND   GND
N2   adcin[93]   2s_ttl33_rrin
N3   TH[109]   2s_ttl33_rrin
N4   adcin[49]   2s_ttl33_rrin
N5   adcin[47]   2s_ttl33_rrin
N6   TH[51]   2s_ttl33_rtin
N7   TH[60]   2s_ttl33_rtin
N8   TH[50]   2s_ttl33_rtin
N9   adcin[51]   2s_ttl33_rtin
N10   NC   NC
N11   NC   NC
N12   VCCPD5   POWER
N13   VCCINT   POWER
N14   GND   GND
N15   VCCINT   POWER
N16   GND   GND
N17   VCCINT   POWER
N18   GND   GND
N19   VCCINT   POWER
N20   GND   GND
N21   VCCPD2   POWER
N23   TH[220]   2s_ttl33_rtin
N24   adcin[190]   2s_ttl33_rtin
N25   TH[211]   2s_ttl33_rtin
N26   adcin[186]   2s_ttl33_rtin
N27   adcin[189]   2s_ttl33_rtin
N28   TH[221]   2s_ttl33_rrin
N29   TH[219]   2s_ttl33_rrin
N30   TH[138]   2s_ttl33_rrin
N31   TH[128]   2s_ttl33_rrin
N32   GND   GND
P1   adcin[87]   2s_ttl33_rrin
P2   adcin[85]   2s_ttl33_rrin
P3   VREFB5   POWER
P4   adcin[48]   2s_ttl33_rtin
P5   TH[55]   2s_ttl33_rtin
P6   adcin[54]   2s_ttl33_rtin
P7   adcin[55]   2s_ttl33_rtin
P8   adcin[53]   2s_ttl33_rtin
P9   adcin[46]   2s_ttl33_rtin
P10   TH[53]   2s_ttl33_rtin
P11   TH[54]   2s_ttl33_rtin
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[Diff Pin]  inv_pin  vdiff  tdelay_typ  tdelay_min  tdelay_max
U28   U27   NA   NA   NA   NA
| Models and submodels in the file (9): 2s_ttl33_cin (Input), 2s_ttl33_rrin (Input), 2s_ttl33_rtin (Input), 2s_ttl33_nceo (I/O), 2s_ttl33_nstatus (I/O_open_drain), 2s_ttl33_dclk (I/O), 2s_ttl33_tdo (Output), 2s_ttl33_cfdone (I/O_open_drain), 2s_lvds25_ro (3-state)
